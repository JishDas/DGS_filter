# Ansys Electronics Desktop project, version 2023.2
materials:
  vacuum: permittivity=1
  FR4_epoxy: permittivity=4.4 dielectric_loss_tangent=0.02
  air: permittivity=1.0006 permeability=1.0000004
  copper: permeability=0.999991 conductivity=58000000

design 940_942 (HFSS, HFSS Terminal Network, model units mm)
geometry:
  Substrate [FR4_epoxy] = box(corner=(0mm, 0mm, 0mm), size=(75mm, 50mm, 1.6mm))
  Microstrip_line = rectangle(corner=(0mm, 22.5mm, 1.6mm), x_size=75mm, y_size=5mm)
  Ground_plane = rectangle(corner=(0mm, 50mm, 0mm), x_size=75mm, y_size=-50mm)
  Port1 = rectangle(corner=(0mm, 21.5mm, 1.6mm), y_size=7mm, z_size=-1.6mm)
  Port2 = rectangle(corner=(75mm, 21.5mm, 1.6mm), y_size=7mm, z_size=-1.6mm)
  Radiation_box [air] = box(corner=(80mm, 60mm, -2mm), size=(-88mm, -68mm, 10mm))
  Rectangle2 = rectangle(corner=(14.5mm, 23.7mm, 0mm), x_size=42mm, y_size=1mm)
  Etch1 = rectangle(corner=(14.5mm, 25.3mm, 0mm), x_size=42mm, y_size=1mm)
  Rectangle8 = rectangle(corner=(56.5mm, 24.7mm, 0mm), x_size=-1mm, y_size=0.6mm)
  Ground_plane.subtract(Etch1, Rectangle2)
  Ground_plane.subtract(Rectangle8)
  Rectangle9 = rectangle(corner=(14.5mm, 23.7mm, 0mm), x_size=1mm, y_size=-2.4mm)
  Rectangle10 = rectangle(corner=(14.5mm, 26.3mm, 0mm), x_size=1mm, y_size=2.4mm)
  Ground_plane.subtract(Rectangle10, Rectangle9)
  Rectangle11 = rectangle(corner=(14.5mm, 21.3mm, 0mm), x_size=8mm, y_size=-1mm)
  Rectangle12 = rectangle(corner=(14.5mm, 28.7mm, 0mm), x_size=8mm, y_size=1mm)
  Ground_plane.subtract(Rectangle11, Rectangle12)
boundaries and excitations:
  PerfE1: Perfect E Objects=Microstrip_line
  PerfE2: Perfect E Objects=Ground_plane
  Rad1: Radiation Objects=Radiation_box
  1: Lumped Port Objects=Port1 LumpedPortType=Modal Modes{Mode1{IntLine{(0, 25, 0) -> (0, 25, 1.6)} CharImp=Zpi RenormImp=50ohm}} Impedance=50ohm
  2: Lumped Port Objects=Port2 LumpedPortType=Modal Modes{Mode1{IntLine{(75, 25, 0) -> (75, 25, 1.6)} CharImp=Zpi RenormImp=50ohm}} Impedance=50ohm
setups:
  Setup1: HfssDriven Frequency=1GHz MaxDeltaS=0.02 MaximumPasses=6 MinimumPasses=1 MinimumConvergedPasses=1 PercentRefinement=30 BasisOrder=1 PortAccuracy=2 DrivenSolverType="Direct Solver"
    sweep Sweep: 0.1GHz to 2GHz, 401 points; Type=Fast SaveFields
source amplitudes:
  1:1: 1V 0deg
  2:1: 0V 0deg
reports:
  S Parameter Plot 1: dB(S(1,1)), dB(S(2,1)), dB(S(1,2)), dB(S(2,2)) vs Freq on Setup1 : Sweep; markers m1 at 0.9455GHz, m2 at 0.93125GHz, m3 at 0.92175GHz, m4 at 1.3GHz, m5 at 0.708GHz

design 869_874 (HFSS, HFSS Terminal Network, model units mm)
geometry:
  Substrate [FR4_epoxy] = box(corner=(0mm, 0mm, 0mm), size=(75mm, 50mm, 1.6mm))
  Microstrip_line = rectangle(corner=(0mm, 22.4mm, 1.6mm), x_size=75mm, y_size=5.2mm)
  Ground_plane = rectangle(corner=(0mm, 50mm, 0mm), x_size=75mm, y_size=-50mm)
  Etch = rectangle(corner=(11.5mm, 21.7mm, 0mm), x_size=51.2mm, y_size=1mm)
  Rectangle2 = rectangle(corner=(11.5mm, 23.7mm, 0mm), x_size=51.2mm, y_size=1mm)
  Rectangle3 = rectangle(corner=(11.5mm, 21.7mm, 0mm), x_size=1mm, y_size=3mm)
  Etch.unite(Rectangle2, Rectangle3)
  Ground_plane.subtract(Etch)
  Etch1 = rectangle(corner=(11.5mm, 25.3mm, 0mm), x_size=51.2mm, y_size=1mm)
  Rectangle6 = rectangle(corner=(11.5mm, 27.3mm, 0mm), x_size=51.2mm, y_size=1mm)
  Rectangle7 = rectangle(corner=(11.5mm, 25.3mm, 0mm), x_size=1mm, y_size=3mm)
  Ground_plane.subtract(Etch1, Rectangle6, Rectangle7)
  Port1 = rectangle(corner=(0mm, 21.5mm, 1.6mm), y_size=7mm, z_size=-1.6mm)
  Port2 = rectangle(corner=(75mm, 21.5mm, 1.6mm), y_size=7mm, z_size=-1.6mm)
  Radiation_box [air] = box(corner=(80mm, 60mm, -2mm), size=(-88mm, -68mm, 10mm))
boundaries and excitations:
  PerfE1: Perfect E Objects=Microstrip_line
  PerfE2: Perfect E Objects=Ground_plane
  Rad1: Radiation Objects=Radiation_box
  1: Lumped Port Objects=Port1 LumpedPortType=Modal Modes{Mode1{IntLine{(0, 25, 0) -> (0, 25, 1.6)} CharImp=Zpi RenormImp=50ohm}} Impedance=50ohm
  2: Lumped Port Objects=Port2 LumpedPortType=Modal Modes{Mode1{IntLine{(75, 25, 0) -> (75, 25, 1.6)} CharImp=Zpi RenormImp=50ohm}} Impedance=50ohm
setups:
  Setup1: HfssDriven Frequency=0.8GHz MaxDeltaS=0.02 MaximumPasses=6 MinimumPasses=1 MinimumConvergedPasses=1 PercentRefinement=30 BasisOrder=1 PortAccuracy=2 DrivenSolverType="Direct Solver"
    sweep Sweep: 0.1GHz to 1.6GHz, 401 points; Type=Fast SaveFields
source amplitudes:
  1:1: 1V 0deg
  2:1: 0V 0deg
reports:
  S Parameter Plot 1: dB(S(1,1)), dB(S(2,1)), dB(S(1,2)), dB(S(2,2)) vs Freq on Setup1 : Sweep; markers m1 at 0.88GHz, m2 at 0.86125GHz, m3 at 0.895GHz, m4 at 0.7225GHz, m5 at 1.4875GHz

design 535_540 (HFSS, HFSS Terminal Network, model units mm)
geometry:
  Substrate [FR4_epoxy] = box(corner=(0mm, 0mm, 0mm), size=(75mm, 50mm, 1.6mm))
  Microstrip_line = rectangle(corner=(0mm, 22.4mm, 1.6mm), x_size=75mm, y_size=5.2mm)
  Ground_plane = rectangle(corner=(0mm, 50mm, 0mm), x_size=75mm, y_size=-50mm)
  Port1 = rectangle(corner=(0mm, 21.5mm, 1.6mm), y_size=7mm, z_size=-1.6mm)
  Port2 = rectangle(corner=(75mm, 21.5mm, 1.6mm), y_size=7mm, z_size=-1.6mm)
  Radiation_box [air] = box(corner=(80mm, 60mm, -2mm), size=(-88mm, -68mm, 10mm))
  Rectangle2 = rectangle(corner=(0.5mm, 23.7mm, 0mm), x_size=72mm, y_size=1mm)
  Rectangle3 = rectangle(corner=(0.5mm, 23.7mm, 0mm), x_size=1mm, y_size=-5mm)
  Etch1 = rectangle(corner=(0.5mm, 25.3mm, 0mm), x_size=72mm, y_size=1mm)
  Rectangle7 = rectangle(corner=(0.5mm, 26.3mm, 0mm), x_size=1mm, y_size=5mm)
  Rectangle12 = rectangle(corner=(71.5mm, 26.3mm, 0mm), x_size=1mm, y_size=-2.6mm)
  Ground_plane.subtract(Etch1, Rectangle12, Rectangle2)
  Rectangle13 = rectangle(corner=(0.5mm, 31.3mm, 0mm), x_size=20mm, y_size=1mm)
  Rectangle14 = rectangle(corner=(0.5mm, 17.7mm, 0mm), x_size=20mm, y_size=1mm)
  Ground_plane.subtract(Rectangle13, Rectangle3, Rectangle7)
  Ground_plane.subtract(Rectangle14)
boundaries and excitations:
  PerfE1: Perfect E Objects=Microstrip_line
  PerfE2: Perfect E Objects=Ground_plane
  Rad1: Radiation Objects=Radiation_box
  1: Lumped Port Objects=Port1 LumpedPortType=Modal Modes{Mode1{IntLine{(0, 25, 0) -> (0, 25, 1.6)} CharImp=Zpi RenormImp=50ohm}} Impedance=50ohm
  2: Lumped Port Objects=Port2 LumpedPortType=Modal Modes{Mode1{IntLine{(75, 25, 0) -> (75, 25, 1.6)} CharImp=Zpi RenormImp=50ohm}} Impedance=50ohm
setups:
  Setup1: HfssDriven Frequency=0.5GHz MaxDeltaS=0.02 MaximumPasses=6 MinimumPasses=1 MinimumConvergedPasses=1 PercentRefinement=30 BasisOrder=1 PortAccuracy=2 DrivenSolverType="Direct Solver"
    sweep Sweep: 0.1GHz to 2GHz, 801 points; Type=Fast SaveFields
source amplitudes:
  1:1: 1V 0deg
  2:1: 0V 0deg
reports:
  S Parameter Plot 1: dB(S(1,1)), dB(S(2,1)), dB(S(1,2)), dB(S(2,2)) vs Freq on Setup1 : Sweep; markers m1 at 0.4GHz, m2 at 0.53GHz, m3 at 0.54GHz, m4 at 1.1545GHz, m5 at 0.53225GHz

design HFSSDesign1 (HFSS, HFSS Terminal Network, model units mm)
geometry:
  Substrate [FR4_epoxy] = box(corner=(-37.5mm, -25mm, 0mm), size=(75mm, 50mm, 1.6mm))
  Ground_plane [vacuum] = imported_body()
  Microstrip_line = rectangle(corner=(-37.5mm, -1.5mm, 1.6mm), x_size=75mm, y_size=3mm)
  LI_TL = rectangle(corner=(16.642mm, -2.105mm, 1.6mm), x_size=4.21mm, y_size=4.21mm)
  LI_TL1 = rectangle(corner=(-20.855mm, -2.105mm, 1.6mm), x_size=4.21mm, y_size=4.21mm)
  Microstrip_line.unite(LI_TL, LI_TL1)
  Port1 = rectangle(corner=(37.5mm, -2.5mm, 1.6mm), y_size=5mm, z_size=-1.6mm)
  Port2 = rectangle(corner=(-37.5mm, -2.5mm, 1.6mm), y_size=5mm, z_size=-1.6mm)
  Radiation_box [air] = box(corner=(-44mm, -34mm, -5mm), size=(92mm, 70mm, 20mm))
boundaries and excitations:
  PerfE1: Perfect E Objects=Ground_plane
  PerfE2: Perfect E Objects=Microstrip_line
  Rad1: Radiation Objects=Radiation_box
  1: Lumped Port Objects=Port1 LumpedPortType=Modal Modes{Mode1{IntLine{(37.5, 0, 0) -> (37.5, 0, 1.6)} CharImp=Zpi RenormImp=50ohm}} Impedance=50ohm
  2: Lumped Port Objects=Port2 LumpedPortType=Modal Modes{Mode1{IntLine{(-37.5, 0, 0) -> (-37.5, 0, 1.6)} CharImp=Zpi RenormImp=50ohm}} Impedance=50ohm
setups:
  Setup1: HfssDriven Frequency=1GHz MaxDeltaS=0.02 MaximumPasses=20 MinimumPasses=1 MinimumConvergedPasses=1 PercentRefinement=30 BasisOrder=1 PortAccuracy=2 DrivenSolverType="Direct Solver"
    sweep Sweep: 0.2GHz to 1.2GHz, 401 points; Type=Interpolating SaveFields InterpTolerance=0.5 InterpMaxSolns=250 PassivityErrorTolerance=0.0001
source amplitudes:
  1:1: 1V 0deg
  2:1: 0V 0deg
reports:
  S Parameter Plot 1: dB(S(1,1)), dB(S(2,1)), dB(S(1,2)), dB(S(2,2)) vs Freq on Setup1 : Sweep

design Dumbell_CSRR (HFSS, HFSS Terminal Network, model units mm)
geometry:
  Substrate [FR4_epoxy] = box(corner=(-37.5mm, -25mm, 0mm), size=(75mm, 50mm, 1.6mm))
  Microstrip_line = rectangle(corner=(-37.5mm, -1.5mm, 1.6mm), x_size=75mm, y_size=3mm)
  LI_TL = rectangle(corner=(16.642mm, -2.105mm, 1.6mm), x_size=4.21mm, y_size=4.21mm)
  Port1 = rectangle(corner=(37.5mm, -2.5mm, 1.6mm), y_size=5mm, z_size=-1.6mm)
  Port2 = rectangle(corner=(-37.5mm, -2.5mm, 1.6mm), y_size=5mm, z_size=-1.6mm)
  Radiation_box [air] = box(corner=(-44mm, -34mm, -5mm), size=(92mm, 70mm, 20mm))
  LI_TL1 = rectangle(corner=(-20.855mm, -2.105mm, 1.6mm), x_size=4.21mm, y_size=4.21mm)
  Microstrip_line.unite(LI_TL, LI_TL1)
  Ground_plane [vacuum] = imported_body()
boundaries and excitations:
  PerfE1: Perfect E Objects=Ground_plane
  PerfE2: Perfect E Objects=Microstrip_line
  Rad1: Radiation Objects=Radiation_box
  1: Lumped Port Objects=Port1 LumpedPortType=Modal Modes{Mode1{IntLine{(37.5, 0, 0) -> (37.5, 0, 1.6)} CharImp=Zpi RenormImp=50ohm}} Impedance=50ohm
  2: Lumped Port Objects=Port2 LumpedPortType=Modal Modes{Mode1{IntLine{(-37.5, 0, 0) -> (-37.5, 0, 1.6)} CharImp=Zpi RenormImp=50ohm}} Impedance=50ohm
setups:
  Setup1: HfssDriven Frequency=4GHz MaxDeltaS=0.02 MaximumPasses=6 MinimumPasses=1 MinimumConvergedPasses=1 PercentRefinement=30 BasisOrder=1 PortAccuracy=2 DrivenSolverType="Direct Solver"
    sweep Sweep: 0.5GHz to 12GHz, 1001 points; Type=Fast SaveFields
source amplitudes:
  1:1: 1V 0deg
  2:1: 0V 0deg
reports:
  S Parameter Plot 1: dB(S(1,1)), dB(S(2,1)), dB(S(1,2)), dB(S(2,2)) vs Freq on Setup1 : Sweep

design 925_960 (HFSS, HFSS Terminal Network, model units mm)
geometry:
  Substrate [FR4_epoxy] = box(corner=(-37.5mm, -25mm, 0mm), size=(75mm, 50mm, 1.6mm))
  Ground_plane = rectangle(corner=(-37.5mm, -25mm, 0mm), x_size=75mm, y_size=50mm)
  Rectangle1 = rectangle(corner=(-22mm, -1.3mm, 0mm), x_size=44mm, y_size=1mm)
  Rectangle2 = rectangle(corner=(-22mm, 0.3mm, 0mm), x_size=44mm, y_size=1mm)
  Rectangle3 = rectangle(corner=(-22mm, -0.3mm, 0mm), x_size=1mm, y_size=0.6mm)
  Rectangle4 = rectangle(corner=(22mm, -1.3mm, 0mm), x_size=-1mm, y_size=-2.4mm)
  Rectangle5 = rectangle(corner=(22mm, 3.7mm, 0mm), x_size=-1mm, y_size=-2.4mm)
  Rectangle6 = rectangle(corner=(22mm, -3.7mm, 0mm), x_size=-15mm, y_size=-1mm)
  Rectangle7 = rectangle(corner=(22mm, 4.7mm, 0mm), x_size=-15mm, y_size=-1mm)
  Ground_plane.subtract(Rectangle1..Rectangle7)
  MIcrostrip_line = rectangle(corner=(-37.5mm, -1.5mm, 1.6mm), x_size=75mm, y_size=3mm)
  Rectangle8 = rectangle(corner=(35.8mm, -1.5mm, 1.6mm), x_size=0.4mm, y_size=-3.4mm)
  Rectangle9 = rectangle(corner=(35.8mm, 1.5mm, 1.6mm), x_size=0.4mm, y_size=3.4mm)
  Rectangle10 = rectangle(corner=(-36.2mm, -1.5mm, 1.6mm), x_size=0.4mm, y_size=-3.4mm)
  Rectangle11 = rectangle(corner=(-36.2mm, 1.5mm, 1.6mm), x_size=0.4mm, y_size=3.4mm)
  MIcrostrip_line.unite(Rectangle8..Rectangle11)
  Port1 = rectangle(corner=(-37.5mm, -2.5mm, 1.6mm), y_size=5mm, z_size=-1.6mm)
  Port2 = rectangle(corner=(37.5mm, -2.5mm, 1.6mm), y_size=5mm, z_size=-1.6mm)
  Radiation_box [air] = box(corner=(-60mm, -45mm, -10mm), size=(125mm, 90mm, 35mm))
boundaries and excitations:
  PerfE1: Perfect E Objects=Ground_plane
  PerfE2: Perfect E Objects=MIcrostrip_line
  Rad1: Radiation Objects=Radiation_box
  1: Lumped Port Objects=Port1 LumpedPortType=Modal Modes{Mode1{IntLine{(-37.5, 0, 0) -> (-37.5, 0, 1.6)} CharImp=Zpi RenormImp=50ohm}} Impedance=50ohm
  2: Lumped Port Objects=Port2 LumpedPortType=Modal Modes{Mode1{IntLine{(37.5, 0, 0) -> (37.5, 0, 1.6)} CharImp=Zpi RenormImp=50ohm}} Impedance=50ohm
setups:
  Setup1: HfssDriven Frequency=1GHz MaxDeltaS=0.02 MaximumPasses=6 MinimumPasses=1 MinimumConvergedPasses=1 PercentRefinement=30 BasisOrder=1 PortAccuracy=2 DrivenSolverType="Direct Solver"
    sweep Sweep: 0.1GHz to 1.5GHz, 901 points; Type=Fast SaveFields
source amplitudes:
  1:1: 1V 0deg
  2:1: 0V 0deg
reports:
  S Parameter Plot 1: dB(S(1,1)), dB(S(2,1)), dB(S(1,2)), dB(S(2,2)) vs Freq on Setup1 : Sweep; markers m1 at 1GHz, m2 at 0.55111111GHz, m3 at 0.926GHz, m4 at 0.95088889GHz, m5 at 0.93844444GHz

design 910_950 (HFSS, HFSS Terminal Network, model units mm)
geometry:
  Substrate [FR4_epoxy] = box(corner=(-37.5mm, -25mm, 0mm), size=(75mm, 50mm, 1.6mm))
  Ground_plane = rectangle(corner=(-37.5mm, -25mm, 0mm), x_size=75mm, y_size=50mm)
  Rectangle1 = rectangle(corner=(-22mm, -1.3mm, 0mm), x_size=44mm, y_size=1mm)
  Rectangle2 = rectangle(corner=(-22mm, 0.3mm, 0mm), x_size=44mm, y_size=1mm)
  Rectangle3 = rectangle(corner=(-22mm, -0.3mm, 0mm), x_size=1mm, y_size=0.6mm)
  Rectangle4 = rectangle(corner=(22mm, -1.3mm, 0mm), x_size=-1mm, y_size=-2.4mm)
  Rectangle5 = rectangle(corner=(22mm, 3.7mm, 0mm), x_size=-1mm, y_size=-2.4mm)
  Rectangle6 = rectangle(corner=(22mm, -3.7mm, 0mm), x_size=-15mm, y_size=-1mm)
  Rectangle7 = rectangle(corner=(22mm, 4.7mm, 0mm), x_size=-15mm, y_size=-1mm)
  Ground_plane.subtract(Rectangle1..Rectangle7)
  MIcrostrip_line = rectangle(corner=(-37.5mm, -1.5mm, 1.6mm), x_size=75mm, y_size=3mm)
  Rectangle8 = rectangle(corner=(35.8mm, -1.5mm, 1.6mm), x_size=4mm, y_size=-3.4mm)
  Rectangle9 = rectangle(corner=(35.8mm, 1.5mm, 1.6mm), x_size=4mm, y_size=3.4mm)
  Rectangle10 = rectangle(corner=(-36.2mm, -1.5mm, 1.6mm), x_size=4mm, y_size=-3.4mm)
  Rectangle11 = rectangle(corner=(-36.2mm, 1.5mm, 1.6mm), x_size=4mm, y_size=3.4mm)
  MIcrostrip_line.unite(Rectangle8..Rectangle11)
  Port1 = rectangle(corner=(-37.5mm, -2.5mm, 1.6mm), y_size=5mm, z_size=-1.6mm)
  Port2 = rectangle(corner=(37.5mm, -2.5mm, 1.6mm), y_size=5mm, z_size=-1.6mm)
  Radiation_box [air] = box(corner=(-60mm, -45mm, -10mm), size=(125mm, 90mm, 35mm))
boundaries and excitations:
  PerfE1: Perfect E Objects=Ground_plane
  PerfE2: Perfect E Objects=MIcrostrip_line
  Rad1: Radiation Objects=Radiation_box
  1: Lumped Port Objects=Port1 LumpedPortType=Modal Modes{Mode1{IntLine{(-37.5, 0, 0) -> (-37.5, 0, 1.6)} CharImp=Zpi RenormImp=50ohm}} Impedance=50ohm
  2: Lumped Port Objects=Port2 LumpedPortType=Modal Modes{Mode1{IntLine{(37.5, 0, 0) -> (37.5, 0, 1.6)} CharImp=Zpi RenormImp=50ohm}} Impedance=50ohm
setups:
  Setup1: HfssDriven Frequency=1GHz MaxDeltaS=0.02 MaximumPasses=6 MinimumPasses=1 MinimumConvergedPasses=1 PercentRefinement=30 BasisOrder=1 PortAccuracy=2 DrivenSolverType="Direct Solver"
    sweep Sweep: 0.1GHz to 1.5GHz, 901 points; Type=Fast SaveFields
source amplitudes:
  1:1: 1V 0deg
  2:1: 0V 0deg
reports:
  S Parameter Plot 1: dB(S(1,1)), dB(S(2,1)), dB(S(1,2)), dB(S(2,2)) vs Freq on Setup1 : Sweep; markers m1 at 0.91511111GHz, m2 at 0.95244444GHz, m3 at 1.2868889GHz, m4 at 0.57755556GHz, m5 at 0.94311111GHz

design 925_960_2 (HFSS, HFSS Terminal Network, model units mm)
geometry:
  Substrate [FR4_epoxy] = box(corner=(-37.5mm, -25mm, 0mm), size=(75mm, 50mm, 1.6mm))
  Ground_plane = rectangle(corner=(-37.5mm, -25mm, 0mm), x_size=75mm, y_size=50mm)
  Rectangle1 = rectangle(corner=(-21.2mm, -1.8mm, 0mm), x_size=42.4mm, y_size=1mm)
  Rectangle2 = rectangle(corner=(-21.2mm, 0.8mm, 0mm), x_size=42.4mm, y_size=1mm)
  Rectangle3 = rectangle(corner=(-21.2mm, -0.8mm, 0mm), x_size=1mm, y_size=1.6mm)
  Rectangle4 = rectangle(corner=(21.2mm, -1.8mm, 0mm), x_size=-1mm, y_size=-2.4mm)
  Rectangle5 = rectangle(corner=(21.2mm, 4.2mm, 0mm), x_size=-1mm, y_size=-2.4mm)
  Rectangle6 = rectangle(corner=(21.2mm, -4.2mm, 0mm), x_size=-15.4mm, y_size=-1mm)
  Rectangle7 = rectangle(corner=(21.2mm, 5.2mm, 0mm), x_size=-15.4mm, y_size=-1mm)
  Ground_plane.subtract(Rectangle1..Rectangle7)
  MIcrostrip_line = rectangle(corner=(-37.5mm, -1.5mm, 1.6mm), x_size=75mm, y_size=3mm)
  Rectangle8 = rectangle(corner=(35.8mm, -1.5mm, 1.6mm), x_size=0.4mm, y_size=-3.4mm)
  Rectangle9 = rectangle(corner=(35.8mm, 1.5mm, 1.6mm), x_size=0.4mm, y_size=3.4mm)
  Rectangle10 = rectangle(corner=(-36.2mm, -1.5mm, 1.6mm), x_size=0.4mm, y_size=-3.4mm)
  Rectangle11 = rectangle(corner=(-36.2mm, 1.5mm, 1.6mm), x_size=0.4mm, y_size=3.4mm)
  MIcrostrip_line.unite(Rectangle8..Rectangle11)
  Port1 = rectangle(corner=(-37.5mm, -2.5mm, 1.6mm), y_size=5mm, z_size=-1.6mm)
  Port2 = rectangle(corner=(37.5mm, -2.5mm, 1.6mm), y_size=5mm, z_size=-1.6mm)
  Radiation_box [air] = box(corner=(-60mm, -45mm, -10mm), size=(125mm, 90mm, 35mm))
boundaries and excitations:
  PerfE1: Perfect E Objects=Ground_plane
  PerfE2: Perfect E Objects=MIcrostrip_line
  Rad1: Radiation Objects=Radiation_box
  1: Lumped Port Objects=Port1 LumpedPortType=Modal Modes{Mode1{IntLine{(-37.5, 0, 0) -> (-37.5, 0, 1.6)} CharImp=Zpi RenormImp=50ohm}} Impedance=50ohm
  2: Lumped Port Objects=Port2 LumpedPortType=Modal Modes{Mode1{IntLine{(37.5, 0, 0) -> (37.5, 0, 1.6)} CharImp=Zpi RenormImp=50ohm}} Impedance=50ohm
setups:
  Setup1: HfssDriven Frequency=1GHz MaxDeltaS=0.02 MaximumPasses=6 MinimumPasses=1 MinimumConvergedPasses=1 PercentRefinement=30 BasisOrder=1 PortAccuracy=2 DrivenSolverType="Direct Solver"
    sweep Sweep: 0.1GHz to 1.5GHz, 901 points; Type=Fast SaveFields
source amplitudes:
  1:1: 1V 0deg
  2:1: 0V 0deg
reports:
  S Parameter Plot 1: dB(S(1,1)), dB(S(2,1)), dB(S(1,2)), dB(S(2,2)) vs Freq on Setup1 : Sweep; markers m1 at 0.60088889GHz, m2 at 1.38GHz, m3 at 0.282GHz, m4 at 0.925GHz, m5 at 0.94GHz, m6 at 0.96GHz, m7 at 0.91355556GHz, m8 at 0.96488889GHz, m9 at 1GHz

design 925_960_Final (HFSS, HFSS Terminal Network, model units mm)
geometry:
  Substrate [FR4_epoxy] = box(corner=(-37.5mm, -25mm, 0mm), size=(75mm, 50mm, 1.6mm))
  Ground_plane = rectangle(corner=(-37.5mm, -25mm, 0mm), x_size=75mm, y_size=50mm)
  Rectangle1 = rectangle(corner=(-21.5mm, -1.3mm, 0mm), x_size=43mm, y_size=1mm)
  Rectangle2 = rectangle(corner=(-21.5mm, 0.3mm, 0mm), x_size=43mm, y_size=1mm)
  Rectangle3 = rectangle(corner=(-21.5mm, -0.3mm, 0mm), x_size=1mm, y_size=0.6mm)
  Rectangle4 = rectangle(corner=(21.5mm, -1.3mm, 0mm), x_size=-1mm, y_size=-4.4mm)
  Rectangle5 = rectangle(corner=(21.5mm, 5.7mm, 0mm), x_size=-1mm, y_size=-4.4mm)
  Rectangle6 = rectangle(corner=(21.5mm, -5.7mm, 0mm), x_size=-15mm, y_size=-1mm)
  Rectangle7 = rectangle(corner=(21.5mm, 6.7mm, 0mm), x_size=-15mm, y_size=-1mm)
  Ground_plane.subtract(Rectangle1..Rectangle7)
  MIcrostrip_line = rectangle(corner=(-37.5mm, -1.5mm, 1.6mm), x_size=75mm, y_size=3mm)
  Rectangle8 = rectangle(corner=(35.8mm, -1.5mm, 1.6mm), x_size=0.4mm, y_size=-3.4mm)
  Rectangle9 = rectangle(corner=(35.8mm, 1.5mm, 1.6mm), x_size=0.4mm, y_size=3.4mm)
  Rectangle10 = rectangle(corner=(-36.2mm, -1.5mm, 1.6mm), x_size=0.4mm, y_size=-3.4mm)
  Rectangle11 = rectangle(corner=(-36.2mm, 1.5mm, 1.6mm), x_size=0.4mm, y_size=3.4mm)
  MIcrostrip_line.unite(Rectangle8..Rectangle11)
  Port1 = rectangle(corner=(-37.5mm, -2.5mm, 1.6mm), y_size=5mm, z_size=-1.6mm)
  Port2 = rectangle(corner=(37.5mm, -2.5mm, 1.6mm), y_size=5mm, z_size=-1.6mm)
  Radiation_box [air] = box(corner=(-60mm, -45mm, -10mm), size=(125mm, 90mm, 35mm))
boundaries and excitations:
  PerfE1: Perfect E Objects=Ground_plane
  PerfE2: Perfect E Objects=MIcrostrip_line
  Rad1: Radiation Objects=Radiation_box
  1: Lumped Port Objects=Port1 LumpedPortType=Modal Modes{Mode1{IntLine{(-37.5, 0, 0) -> (-37.5, 0, 1.6)} CharImp=Zpi RenormImp=50ohm}} Impedance=50ohm
  2: Lumped Port Objects=Port2 LumpedPortType=Modal Modes{Mode1{IntLine{(37.5, 0, 0) -> (37.5, 0, 1.6)} CharImp=Zpi RenormImp=50ohm}} Impedance=50ohm
setups:
  Setup1: HfssDriven Frequency=1GHz MaxDeltaS=0.02 MaximumPasses=6 MinimumPasses=1 MinimumConvergedPasses=1 PercentRefinement=30 BasisOrder=1 PortAccuracy=2 DrivenSolverType="Direct Solver"
    sweep Sweep: 0.1GHz to 1.5GHz, 901 points; Type=Fast SaveFields
source amplitudes:
  1:1: 1V 0deg
  2:1: 0V 0deg
reports:
  S Parameter Plot 1: dB(S(1,1)), dB(S(2,1)), dB(S(1,2)), dB(S(2,2)) vs Freq on Setup1 : Sweep; markers m1 at 0.93222222GHz, m2 at 0.925GHz, m3 at 0.96GHz, m4 at 0.68488889GHz, m5 at 1.0908889GHz, m6 at 0.27733333GHz, m7 at 0.94777778GHz

design 925_960_4 (HFSS, HFSS Terminal Network, model units mm)
geometry:
  Substrate [FR4_epoxy] = box(corner=(-37.5mm, -25mm, 0mm), size=(75mm, 50mm, 1.6mm))
  Ground_plane = rectangle(corner=(-37.5mm, -25mm, 0mm), x_size=75mm, y_size=50mm)
  Rectangle1 = rectangle(corner=(-21.7mm, -1.8mm, 0mm), x_size=43.4mm, y_size=1mm)
  Rectangle2 = rectangle(corner=(-21.7mm, 0.8mm, 0mm), x_size=43.4mm, y_size=1mm)
  Rectangle3 = rectangle(corner=(-21.7mm, -0.8mm, 0mm), x_size=1mm, y_size=1.6mm)
  Rectangle4 = rectangle(corner=(21.7mm, -1.8mm, 0mm), x_size=-1mm, y_size=-4.4mm)
  Rectangle5 = rectangle(corner=(21.7mm, 6.2mm, 0mm), x_size=-1mm, y_size=-4.4mm)
  Rectangle6 = rectangle(corner=(21.7mm, -6.2mm, 0mm), x_size=-15mm, y_size=-1mm)
  Rectangle7 = rectangle(corner=(21.7mm, 7.2mm, 0mm), x_size=-15mm, y_size=-1mm)
  Ground_plane.subtract(Rectangle1..Rectangle7)
  MIcrostrip_line = rectangle(corner=(-37.5mm, -1.5mm, 1.6mm), x_size=75mm, y_size=3mm)
  Rectangle8 = rectangle(corner=(35.8mm, -1.5mm, 1.6mm), x_size=0.4mm, y_size=-3.4mm)
  Rectangle9 = rectangle(corner=(35.8mm, 1.5mm, 1.6mm), x_size=0.4mm, y_size=3.4mm)
  Rectangle10 = rectangle(corner=(-36.2mm, -1.5mm, 1.6mm), x_size=0.4mm, y_size=-3.4mm)
  Rectangle11 = rectangle(corner=(-36.2mm, 1.5mm, 1.6mm), x_size=0.4mm, y_size=3.4mm)
  MIcrostrip_line.unite(Rectangle8..Rectangle11)
  Port1 = rectangle(corner=(-37.5mm, -2.5mm, 1.6mm), y_size=5mm, z_size=-1.6mm)
  Port2 = rectangle(corner=(37.5mm, -2.5mm, 1.6mm), y_size=5mm, z_size=-1.6mm)
  Radiation_box [air] = box(corner=(-60mm, -45mm, -10mm), size=(125mm, 90mm, 35mm))
boundaries and excitations:
  PerfE1: Perfect E Objects=Ground_plane
  PerfE2: Perfect E Objects=MIcrostrip_line
  Rad1: Radiation Objects=Radiation_box
  1: Lumped Port Objects=Port1 LumpedPortType=Modal Modes{Mode1{IntLine{(-37.5, 0, 0) -> (-37.5, 0, 1.6)} CharImp=Zpi RenormImp=50ohm}} Impedance=50ohm
  2: Lumped Port Objects=Port2 LumpedPortType=Modal Modes{Mode1{IntLine{(37.5, 0, 0) -> (37.5, 0, 1.6)} CharImp=Zpi RenormImp=50ohm}} Impedance=50ohm
setups:
  Setup1: HfssDriven Frequency=1GHz MaxDeltaS=0.02 MaximumPasses=6 MinimumPasses=1 MinimumConvergedPasses=1 PercentRefinement=30 BasisOrder=1 PortAccuracy=2 DrivenSolverType="Direct Solver"
    sweep Sweep: 0.1GHz to 1.5GHz, 901 points; Type=Fast SaveFields
source amplitudes:
  1:1: 1V 0deg
  2:1: 0V 0deg
reports:
  S Parameter Plot 1: dB(S(1,1)), dB(S(2,1)), dB(S(1,2)), dB(S(2,2)) vs Freq on Setup1 : Sweep; markers m1 at 0.88244444GHz, m2 at 0.925GHz, m3 at 0.55577778GHz, m4 at 1GHz

design Coplanar_waveguide (HFSS, HFSS Terminal Network, model units mm)
geometry:
  Box1 [FR4_epoxy] = box(corner=(-37.5mm, -25mm, 0mm), size=(75mm, 50mm, 1.4mm))
  Microstrip_line = rectangle(corner=(-37.5mm, -1.25mm, 1.4mm), x_size=75mm, y_size=2.5mm)
  Top_ground = rectangle(corner=(-37.5mm, -25mm, 1.4mm), x_size=75mm, y_size=22.25mm)
  Top_ground1 = rectangle(corner=(-37.5mm, 2.75mm, 1.4mm), x_size=75mm, y_size=22.25mm)
  Ground_plane = rectangle(corner=(-37.5mm, -25mm, 0mm), x_size=75mm, y_size=50mm)
  Rectangle1 = rectangle(corner=(-21.5mm, -1.9mm, 0mm), x_size=43mm, y_size=-1mm)
  Rectangle2 = rectangle(corner=(-21.5mm, 1.95mm, 0mm), x_size=43mm, y_size=1mm)
  Rectangle3 = rectangle(corner=(-21.5mm, -1.95mm, 0mm), x_size=1mm, y_size=3.9mm)
  Port1 = rectangle(corner=(-37.5mm, -2mm, 1.4mm), y_size=4mm, z_size=-1.4mm)
  Port2 = rectangle(corner=(37.5mm, -2mm, 1.4mm), y_size=4mm, z_size=-1.4mm)
  Radiation_box [air] = box(corner=(-60mm, -45mm, -10mm), size=(125mm, 90mm, 35mm))
  Ground_plane.subtract(Rectangle1, Rectangle2, Rectangle3)
  Via0 [copper] = cylinder(axis=Z, base_centre=(-7.5mm, 3.5mm, 0mm), radius=0.1mm, height=1.4mm)
  Via1 [copper] = cylinder(axis=Z, base_centre=(-7.5mm, -3.5mm, 0mm), radius=0.1mm, height=1.4mm)
  Via2 [copper] = cylinder(axis=Z, base_centre=(-15mm, 3.5mm, 0mm), radius=0.1mm, height=1.4mm)
  Via3 [copper] = cylinder(axis=Z, base_centre=(-15mm, -3.5mm, 0mm), radius=0.1mm, height=1.4mm)
  Via4 [copper] = cylinder(axis=Z, base_centre=(-22.5mm, 3.5mm, 0mm), radius=0.1mm, height=1.4mm)
  Via5 [copper] = cylinder(axis=Z, base_centre=(-22.5mm, -3.5mm, 0mm), radius=0.1mm, height=1.4mm)
  Via6 [copper] = cylinder(axis=Z, base_centre=(-30mm, 3.5mm, 0mm), radius=0.1mm, height=1.4mm)
  Via7 [copper] = cylinder(axis=Z, base_centre=(-30mm, -3.5mm, 0mm), radius=0.1mm, height=1.4mm)
  Via8 [copper] = cylinder(axis=Z, base_centre=(0mm, 3.5mm, 0mm), radius=0.1mm, height=1.4mm)
  Via9 [copper] = cylinder(axis=Z, base_centre=(0mm, -3.5mm, 0mm), radius=0.1mm, height=1.4mm)
  Via10 [copper] = cylinder(axis=Z, base_centre=(7.5mm, 3.5mm, 0mm), radius=0.1mm, height=1.4mm)
  Via11 [copper] = cylinder(axis=Z, base_centre=(7.5mm, -3.5mm, 0mm), radius=0.1mm, height=1.4mm)
  Via12 [copper] = cylinder(axis=Z, base_centre=(15mm, 3.5mm, 0mm), radius=0.1mm, height=1.4mm)
  Via13 [copper] = cylinder(axis=Z, base_centre=(15mm, -3.5mm, 0mm), radius=0.1mm, height=1.4mm)
  Via14 [copper] = cylinder(axis=Z, base_centre=(22.5mm, 3.5mm, 0mm), radius=0.1mm, height=1.4mm)
  Via15 [copper] = cylinder(axis=Z, base_centre=(22.5mm, -3.5mm, 0mm), radius=0.1mm, height=1.4mm)
  Via16 [copper] = cylinder(axis=Z, base_centre=(30mm, 3.5mm, 0mm), radius=0.1mm, height=1.4mm)
  Via17 [copper] = cylinder(axis=Z, base_centre=(30mm, -3.5mm, 0mm), radius=0.1mm, height=1.4mm)
boundaries and excitations:
  PerfE1: Perfect E Objects=Ground_plane
  PerfE2: Perfect E Objects=[Microstrip_line, Top_ground, Top_ground1]
  Rad1: Radiation Objects=Radiation_box
  1: Lumped Port Objects=Port1 LumpedPortType=Modal Modes{Mode1{IntLine{(-37.5, 0, 0) -> (-37.5, 0, 1.4)} CharImp=Zpi RenormImp=50ohm}} Impedance=50ohm
  2: Lumped Port Objects=Port2 LumpedPortType=Modal Modes{Mode1{IntLine{(37.5, 0, 0) -> (37.5, 0, 1.4)} CharImp=Zpi RenormImp=50ohm}} Impedance=50ohm
setups:
  Setup1: HfssDriven Frequency=1GHz MaxDeltaS=0.02 MaximumPasses=6 MinimumPasses=1 MinimumConvergedPasses=1 PercentRefinement=30 BasisOrder=1 PortAccuracy=2 DrivenSolverType="Direct Solver"
    sweep Sweep: 0.1GHz to 1.5GHz, 901 points; Type=Fast SaveFields
source amplitudes:
  1:1: 1V 0deg
  2:1: 0V 0deg
reports:
  S Parameter Plot 1: dB(S(1,1)), dB(S(2,1)), dB(S(1,2)), dB(S(2,2)) vs Freq on Setup1 : Sweep; markers m1 at 0.786GHz, m2 at 0.96644444GHz, m3 at 1.0831111GHz, m4 at 1.1624444GHz, m5 at 1.2931111GHz, m6 at 1.0224444GHz
